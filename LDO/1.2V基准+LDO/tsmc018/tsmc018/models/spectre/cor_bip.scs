library bip_cor

section ff_bip
include "cr018gpii_v1d0.scs" section = ff_bip
endsection ff_bip

section ss_bip
include "cr018gpii_v1d0.scs" section = ss_bip
endsection ss_bip

section tt_bip
include "cr018gpii_v1d0.scs" section = tt_bip
endsection tt_bip

endlibrary bip_cor
