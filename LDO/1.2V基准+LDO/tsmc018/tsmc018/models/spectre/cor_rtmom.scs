library rtmom_cor

section ff_rtmom
include "cr018gpii_v1d0.scs" section = ff_rtmom
endsection ff_rtmom

section ss_rtmom
include "cr018gpii_v1d0.scs" section = ss_rtmom
endsection ss_rtmom

section tt_rtmom
include "cr018gpii_v1d0.scs" section = tt_rtmom
endsection tt_rtmom

endlibrary rtmom_cor
