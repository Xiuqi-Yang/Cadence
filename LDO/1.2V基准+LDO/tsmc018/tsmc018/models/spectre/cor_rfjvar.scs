library rfjvar_cor

section ff_rfjvar
include "cr018gpii_v1d0.scs" section = ff_rfjvar
endsection ff_rfjvar

section ss_rfjvar
include "cr018gpii_v1d0.scs" section = ss_rfjvar
endsection ss_rfjvar

section tt_rfjvar
include "cr018gpii_v1d0.scs" section = tt_rfjvar
endsection tt_rfjvar

endlibrary rfjvar_cor
