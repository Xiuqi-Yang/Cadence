library rfmim_cor

section ff_rfmim
include "cr018gpii_v1d0.scs" section = ff_rfmim
endsection ff_rfmim

section ss_rfmim
include "cr018gpii_v1d0.scs" section = ss_rfmim
endsection ss_rfmim

section tt_rfmim
include "cr018gpii_v1d0.scs" section = tt_rfmim
endsection tt_rfmim

endlibrary rfmim_cor
