library bbmvar_cor

section ff_bbmvar
include "cr018gpii_v1d0.scs" section = ff_bbmvar
endsection ff_bbmvar

section ss_bbmvar
include "cr018gpii_v1d0.scs" section = ss_bbmvar
endsection ss_bbmvar

section tt_bbmvar
include "cr018gpii_v1d0.scs" section = tt_bbmvar
endsection tt_bbmvar

endlibrary bbmvar_cor
