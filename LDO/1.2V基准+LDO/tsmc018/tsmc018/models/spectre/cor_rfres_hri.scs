library rfres_hri_cor

section ff_rfres_hri
include "cr018gpii_v1d0.scs" section = ff_rfres_hri
endsection ff_rfres_hri

section ss_rfres_hri
include "cr018gpii_v1d0.scs" section = ss_rfres_hri
endsection ss_rfres_hri

section tt_rfres_hri
include "cr018gpii_v1d0.scs" section = tt_rfres_hri
endsection tt_rfres_hri

endlibrary rfres_hri_cor
