library m_cor

section ff_m
include "cr018gpii_v1d0.scs" section = ff_m
endsection ff_m

section fs_m
include "cr018gpii_v1d0.scs" section = fs_m
endsection fs_m

section sf_m
include "cr018gpii_v1d0.scs" section = sf_m
endsection sf_m

section ss_m
include "cr018gpii_v1d0.scs" section = ss_m
endsection ss_m

section tt_m
include "cr018gpii_v1d0.scs" section = tt_m
endsection tt_m

endlibrary m_cor
