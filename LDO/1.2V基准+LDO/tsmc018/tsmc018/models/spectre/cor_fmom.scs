library fmom_cor

section ff_fmom
include "cr018gpii_v1d0.scs" section = ff_fmom
endsection ff_fmom

section ss_fmom
include "cr018gpii_v1d0.scs" section = ss_fmom
endsection ss_fmom

section tt_fmom
include "cr018gpii_v1d0.scs" section = tt_fmom
endsection tt_fmom

endlibrary fmom_cor
