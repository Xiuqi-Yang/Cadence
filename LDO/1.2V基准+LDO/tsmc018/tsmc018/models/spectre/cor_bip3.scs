library bip3_cor

section ff_bip3
include "cr018gpii_v1d0.scs" section = ff_bip3
endsection ff_bip3

section ss_bip3
include "cr018gpii_v1d0.scs" section = ss_bip3
endsection ss_bip3

section tt_bip3
include "cr018gpii_v1d0.scs" section = tt_bip3
endsection tt_bip3

endlibrary bip3_cor
