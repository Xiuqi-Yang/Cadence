library dio_3m_cor

section ff_dio_3m
include "cr018gpii_v1d0.scs" section = ff_dio_3m
endsection ff_dio_3m

section ss_dio_3m
include "cr018gpii_v1d0.scs" section = ss_dio_3m
endsection ss_dio_3m

section tt_dio_3m
include "cr018gpii_v1d0.scs" section = tt_dio_3m
endsection tt_dio_3m

endlibrary dio_3m_cor
