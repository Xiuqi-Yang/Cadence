library rfsbd_cor

section ff_rfsbd
include "cr018gpii_v1d0.scs" section = ff_rfsbd
endsection ff_rfsbd

section ss_rfsbd
include "cr018gpii_v1d0.scs" section = ss_rfsbd
endsection ss_rfsbd

section tt_rfsbd
include "cr018gpii_v1d0.scs" section = tt_rfsbd
endsection tt_rfsbd

endlibrary rfsbd_cor
