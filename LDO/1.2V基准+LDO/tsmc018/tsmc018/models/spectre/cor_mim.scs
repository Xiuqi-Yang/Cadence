library mim_cor

section ff_mim
include "cr018gpii_v1d0.scs" section = ff_mim
endsection ff_mim

section ss_mim
include "cr018gpii_v1d0.scs" section = ss_mim
endsection ss_mim

section tt_mim
include "cr018gpii_v1d0.scs" section = tt_mim
endsection tt_mim

endlibrary mim_cor
