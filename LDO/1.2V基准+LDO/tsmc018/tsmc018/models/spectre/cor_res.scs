library res_cor

section ff_res
include "cr018gpii_v1d0.scs" section = ff_res
endsection ff_res

section ss_res
include "cr018gpii_v1d0.scs" section = ss_res
endsection ss_res

section tt_res
include "cr018gpii_v1d0.scs" section = tt_res
endsection tt_res

endlibrary res_cor
